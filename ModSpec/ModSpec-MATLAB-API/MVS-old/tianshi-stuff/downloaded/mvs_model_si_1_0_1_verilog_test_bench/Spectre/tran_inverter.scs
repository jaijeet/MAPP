// Test-bench for generting transient response of an inverter with two loading scenarios:
// scenario 1: You can choose either c1=1pF (constant loading) by uncommenting line 25
// scenario 2: You can have lines 26-29 uncommented for simulating a fan-out of FOUR.

// TESTED ON SPECTRE Version 10.1.1.374.isr21
simulator lang=spectre
ahdl_include "mvs_si_1_0_1.va"
format options rawfmt=psfascii

//Library name: mvs_si_1_0_1
subckt inverter Vin Vout Vvdd Vgnd
I1 (Vvdd Vin Vout Vvdd) mvs_si_1_0_1 type=-1 W=1.0e-4 Lgdr=32e-7 \
         dLg=8e-7 Cg=2.57e-6 beta=1.8 alpha=3.5 Tjun=300\
	 Cif = 1.38e-12 Cof=1.47e-12 phib=1.2 gamma=0.1 mc=0.2 CTM_select=1 \
	Rs0=100 Rd0 = 100 n0=1.68 nd=0.1 vxo=7542204 mu=165 Vt0=0.5535 delta=0.15
I0 (Vout Vin Vgnd Vgnd) mvs_si_1_0_1 type=1 W=1e-4 Lgdr=32e-7 \
	dLg=9e-7 Cg=2.57e-6 beta=1.8 alpha=3.5 Tjun=300 \
	Cif=1.38e-12 Cof=1.47e-12 phib=1.2 gamma=0.1 mc=0.2 CTM_select=1 \
	Rs0=100 Rd0=100 n0=1.68 nd=0.1 vxo=1.2e7 mu=200 Vt0=0.4 delta=0.15
ends inverter

Vsup (sup 0) vsource dc=1
Vin (in 0) vsource type=pulse val0=0 val1=1.0 period=100p rise=1p fall=1p width=50p
Inv1 (in out sup 0) inverter
//c1 (out 0) capacitor c=1e-12 // load can be changed.
Inv2 (out out1 sup 0) inverter
Inv3 (out out2 sup 0) inverter
Inv4 (out out3 sup 0) inverter
Inv5 (out out4 sup 0) inverter
c2 (out 0) capacitor c=3e-15

tran_inverter tran step=1p stop=1n method=trap save=all
simulatorOptions options reltol=1e-3 vabstol=1e-6 iabstol=1e-12 temp=27 \
    tnom=27 scalem=1.0 scale=1.0 gmin=1e-12 rforce=1 maxnotes=5 maxwarns=5 \
    digits=5 cols=80 pivrel=1e-3 sensfile="../psf/sens.output" \
    checklimitdest=psf

// add cmin=1e-18 in simulatorOptions line to achieve better convergence.
// check for cmin compatability with older Spectre versions.

// following lines can be uncommented to store results in rawfile.

//modelParameter info what=captab where=rawfile
//element info what=inst where=rawfile
//outputParameter info what=output where=rawfile
//designParamVals info what=parameters where=rawfile
//primitives info what=primitives where=rawfile
//subckts info what=subckts  where=rawfile
//saveOptions options save=allpub
