// Test-bench for generting dc response of an inverter
// TESTED ON SPECTRE Version 10.1.1.374.isr21

simulator lang=spectre
ahdl_include "mvs_si_1_0_1.va"
format options rawfmt=psfascii

//Library name: mvs_si_1_0_1
subckt inverter Vin Vout Vvdd Vgnd
I1 (Vvdd Vin Vout Vvdd) mvs_si_1_0_1 type=-1 W=1.0e-4 Lgdr=32e-7 \
         dLg=8e-7 Cg=2.57e-6 beta=1.8 alpha=3.5 Tjun=300 \
	 Cif = 1.38e-12 Cof=1.47e-12 phib=1.2 gamma=0.1 mc=0.2 CTM_select=1  \
	 Rs0=100 Rd0 = 100 n0=1.68 nd=0.1 vxo=7542204 mu=165 Vt0=0.5535 delta=0.15
I0 (Vout Vin Vgnd Vgnd) mvs_si_1_0_1 type=1 W=1e-4 Lgdr=32e-7 \
	dLg=9e-7 Cg=2.57e-6 beta=1.8 alpha=3.5 Tjun=300\
	Cif=1.38e-12 Cof=1.47e-12 phib=1.2 gamma=0.1 mc=0.2 CTM_select=1 \
	Rs0=100 Rd0=100 n0=1.68 nd=0.1 vxo=1.2e7 mu=200 Vt0=0.4 delta=0.15
ends inverter

parameters vdi=1
parameters vgi=0
Vsup (sup 0) vsource dc=vdi
Vin (in 0) vsource dc=vgi
Inv1 (in out sup 0) inverter

dc_inverter dc param=vgi start=0 stop=1 step=0.01 save=all
